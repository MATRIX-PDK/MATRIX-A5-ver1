.subckt gtA5_cfet_bsc_20_and2_x1_svt A B Y VDD VSS
*.PININFO A:I B:I Y:O VDD:B VSS:B
MM7 Y net20 VDD VDD pmos_svt WGAA=0.020u L=0.012u M=1
MM2 net20 B VDD VDD pmos_svt WGAA=0.020u L=0.012u M=1
MM0 net20 A VDD VDD pmos_svt WGAA=0.020u L=0.012u M=1
MM3 net13 B VSS VSS nmos_svt WGAA=0.020u L=0.012u M=1
MM8 Y net20 VSS VSS nmos_svt WGAA=0.020u L=0.012u M=1
MM1 net20 A net13 VSS nmos_svt WGAA=0.020u L=0.012u M=1
.ends gtA5_cfet_bsc_20_and2_x1_svt
