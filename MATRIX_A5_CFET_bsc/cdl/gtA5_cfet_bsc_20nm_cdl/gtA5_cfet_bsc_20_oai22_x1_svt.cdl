.subckt gtA5_cfet_bsc_20_oai22_x1_svt A1 A2 B1 B2 Y VDD VSS
*.PININFO A1:I A2:I B1:I B2:I Y:O VDD:B VSS:B
MM35 Y B2 net101 VDD pmos_svt WGAA=0.020u L=0.012u M=1
MM27 Y A2 net69 VDD pmos_svt WGAA=0.020u L=0.012u M=1
MM28 net101 B1 VDD VDD pmos_svt WGAA=0.020u L=0.012u M=1
MM26 net69 A1 VDD VDD pmos_svt WGAA=0.020u L=0.012u M=1
MM37 net91 B2 VSS VSS nmos_svt WGAA=0.020u L=0.012u M=1
MM29 net91 B1 VSS VSS nmos_svt WGAA=0.020u L=0.012u M=1
MM31 Y A1 net91 VSS nmos_svt WGAA=0.020u L=0.012u M=1
MM30 Y A2 net91 VSS nmos_svt WGAA=0.020u L=0.012u M=1
.ends gtA5_cfet_bsc_20_oai22_x1_svt
