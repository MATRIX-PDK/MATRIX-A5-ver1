.subckt gtA5_cfet_bsc_20_ao32_x1_svt A1 A2 A3 B1 B2 Y VDD VSS
*.PININFO A1:I A2:I A3:I B1:I B2:I Y:O VDD:B VSS:B
MM18 net98 A3 VSS VSS nmos_svt WGAA=0.020u L=0.012u M=1
MM35 net106 B2 VSS VSS nmos_svt WGAA=0.020u L=0.012u M=1
MM32 net97 A2 net98 VSS nmos_svt WGAA=0.020u L=0.012u M=1
MM19 net91 B1 net106 VSS nmos_svt WGAA=0.020u L=0.012u M=1
MM27 Y net91 VSS VSS nmos_svt WGAA=0.020u L=0.012u M=1
MM17 net91 A1 net97 VSS nmos_svt WGAA=0.020u L=0.012u M=1
MM26 Y net91 VDD VDD pmos_svt WGAA=0.020u L=0.012u M=1
MM34 net91 B2 net92 VDD pmos_svt WGAA=0.020u L=0.012u M=1
MM14 net91 B1 net92 VDD pmos_svt WGAA=0.020u L=0.012u M=1
MM31 net92 A3 VDD VDD pmos_svt WGAA=0.020u L=0.012u M=1
MM29 net92 A2 VDD VDD pmos_svt WGAA=0.020u L=0.012u M=1
MM16 net92 A1 VDD VDD pmos_svt WGAA=0.020u L=0.012u M=1
.ends gtA5_cfet_bsc_20_ao32_x1_svt
