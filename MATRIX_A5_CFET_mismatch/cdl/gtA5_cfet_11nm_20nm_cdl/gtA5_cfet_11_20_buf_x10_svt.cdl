.subckt gtA5_cfet_11_20_buf_x10_svt A Y VDD VSS
*.PININFO A:I Y:O VDD:B VSS:B
MM2 Y net13 VDD VDD pmos_svt WGAA=0.020u L=0.012u M=10
MM0 net13 A VDD VDD pmos_svt WGAA=0.020u L=0.012u M=3
MM3 Y net13 VSS VSS nmos_svt WGAA=0.011u L=0.012u M=10
MM1 net13 A VSS VSS nmos_svt WGAA=0.011u L=0.012u M=3
.ends gtA5_cfet_11_20_buf_x10_svt
