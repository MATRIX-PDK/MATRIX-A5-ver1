.subckt gtA5_cfet_11_20_nand3_x1_svt A B C Y VDD VSS
*.PININFO A:I B:I C:I Y:O VDD:B VSS:B
MM9 Y A VDD VDD pmos_svt WGAA=0.020u L=0.012u M=1
MM2 Y B VDD VDD pmos_svt WGAA=0.020u L=0.012u M=1
MM0 Y C VDD VDD pmos_svt WGAA=0.020u L=0.012u M=1
MM7 net15 A VSS VSS nmos_svt WGAA=0.011u L=0.012u M=1
MM3 net13 B net15 VSS nmos_svt WGAA=0.011u L=0.012u M=1
MM1 Y C net13 VSS nmos_svt WGAA=0.011u L=0.012u M=1
.ends gtA5_cfet_11_20_nand3_x1_svt
