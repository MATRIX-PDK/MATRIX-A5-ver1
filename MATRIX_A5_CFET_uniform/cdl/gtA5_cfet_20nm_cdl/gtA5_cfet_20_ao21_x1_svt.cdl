.subckt gtA5_cfet_20_ao21_x1_svt A1 A2 B Y VDD VSS
*.PININFO A1:I A2:I B:I Y:O VDD:B VSS:B
MM19 net67 B VSS VSS nmos_svt WGAA=0.020u L=0.012u M=1
MM18 net41 A2 VSS VSS nmos_svt WGAA=0.020u L=0.012u M=1
MM17 net67 A1 net41 VSS nmos_svt WGAA=0.020u L=0.012u M=1
MM27 Y net67 VSS VSS nmos_svt WGAA=0.020u L=0.012u M=1
MM16 net64 B VDD VDD pmos_svt WGAA=0.020u L=0.012u M=1
MM26 Y net67 VDD VDD pmos_svt WGAA=0.020u L=0.012u M=1
MM14 net67 A1 net64 VDD pmos_svt WGAA=0.020u L=0.012u M=1
MM15 net67 A2 net64 VDD pmos_svt WGAA=0.020u L=0.012u M=1
.ends gtA5_cfet_20_ao21_x1_svt
