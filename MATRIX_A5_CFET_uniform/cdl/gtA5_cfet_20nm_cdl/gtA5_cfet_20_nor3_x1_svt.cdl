.subckt gtA5_cfet_20_nor3_x1_svt A B C Y VDD VSS
*.PININFO A:I B:I C:I Y:O VDD:B VSS:B
MM9 Y C VSS VSS nmos_svt WGAA=0.020u L=0.012u M=1
MM3 Y B VSS VSS nmos_svt WGAA=0.020u L=0.012u M=1
MM1 Y A VSS VSS nmos_svt WGAA=0.020u L=0.012u M=1
MM7 Y C net24 VDD pmos_svt WGAA=0.020u L=0.012u M=1
MM2 net24 B net22 VDD pmos_svt WGAA=0.020u L=0.012u M=1
MM0 net22 A VDD VDD pmos_svt WGAA=0.020u L=0.012u M=1
.ends gtA5_cfet_20_nor3_x1_svt
