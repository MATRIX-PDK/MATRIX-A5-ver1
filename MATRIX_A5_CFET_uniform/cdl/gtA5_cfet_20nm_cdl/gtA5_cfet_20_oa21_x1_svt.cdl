.subckt gtA5_cfet_20_oa21_x1_svt A1 A2 B Y VDD VSS
*.PININFO A1:I A2:I B:I Y:O VDD:B VSS:B
MM33 Y net98 VDD VDD pmos_svt WGAA=0.020u L=0.012u M=1
MM27 net98 A1 net69 VDD pmos_svt WGAA=0.020u L=0.012u M=1
MM28 net98 B VDD VDD pmos_svt WGAA=0.020u L=0.012u M=1
MM26 net69 A2 VDD VDD pmos_svt WGAA=0.020u L=0.012u M=1
MM29 net91 B VSS VSS nmos_svt WGAA=0.020u L=0.012u M=1
MM34 Y net98 VSS VSS nmos_svt WGAA=0.020u L=0.012u M=1
MM31 net98 A2 net91 VSS nmos_svt WGAA=0.020u L=0.012u M=1
MM30 net98 A1 net91 VSS nmos_svt WGAA=0.020u L=0.012u M=1
.ends gtA5_cfet_20_oa21_x1_svt
