.subckt gtA5_cfet_11_oai32_x1_svt A1 A2 A3 B1 B2 Y VDD VSS
*.PININFO A1:I A2:I A3:I B1:I B2:I Y:O VDD:B VSS:B
MM40 Y B2 net122 VDD pmos_svt WGAA=0.011u L=0.012u M=1
MM35 Y A3 net115 VDD pmos_svt WGAA=0.011u L=0.012u M=1
MM27 net115 A2 net69 VDD pmos_svt WGAA=0.011u L=0.012u M=1
MM28 net122 B1 VDD VDD pmos_svt WGAA=0.011u L=0.012u M=1
MM26 net69 A1 VDD VDD pmos_svt WGAA=0.011u L=0.012u M=1
MM29 net91 B1 VSS VSS nmos_svt WGAA=0.011u L=0.012u M=1
MM38 net91 B2 VSS VSS nmos_svt WGAA=0.011u L=0.012u M=1
MM37 Y A3 net91 VSS nmos_svt WGAA=0.011u L=0.012u M=1
MM31 Y A1 net91 VSS nmos_svt WGAA=0.011u L=0.012u M=1
MM30 Y A2 net91 VSS nmos_svt WGAA=0.011u L=0.012u M=1
.ends gtA5_cfet_11_oai32_x1_svt
