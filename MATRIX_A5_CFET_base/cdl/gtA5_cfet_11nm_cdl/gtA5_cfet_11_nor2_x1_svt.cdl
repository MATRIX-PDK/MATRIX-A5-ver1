.subckt gtA5_cfet_11_nor2_x1_svt A B Y VDD VSS
*.PININFO A:I B:I Y:O VDD:B VSS:B
MM1 Y A VSS VSS nmos_svt WGAA=0.011u L=0.012u M=1
MM3 Y B VSS VSS nmos_svt WGAA=0.011u L=0.012u M=1
MM2 Y B net22 VDD pmos_svt WGAA=0.011u L=0.012u M=1
MM0 net22 A VDD VDD pmos_svt WGAA=0.011u L=0.012u M=1
.ends gtA5_cfet_11_nor2_x1_svt
