.subckt gtA5_cfet_11_oai31_x1_svt A1 A2 A3 B Y VDD VSS
*.PININFO A1:I A2:I A3:I B:I Y:O VDD:B VSS:B
MM35 Y A3 net115 VDD pmos_svt WGAA=0.011u L=0.012u M=1
MM28 Y B VDD VDD pmos_svt WGAA=0.011u L=0.012u M=1
MM27 net115 A2 net69 VDD pmos_svt WGAA=0.011u L=0.012u M=1
MM26 net69 A1 VDD VDD pmos_svt WGAA=0.011u L=0.012u M=1
MM29 net91 B VSS VSS nmos_svt WGAA=0.011u L=0.012u M=1
MM37 Y A3 net91 VSS nmos_svt WGAA=0.011u L=0.012u M=1
MM31 Y A1 net91 VSS nmos_svt WGAA=0.011u L=0.012u M=1
MM30 Y A2 net91 VSS nmos_svt WGAA=0.011u L=0.012u M=1
.ends gtA5_cfet_11_oai31_x1_svt
