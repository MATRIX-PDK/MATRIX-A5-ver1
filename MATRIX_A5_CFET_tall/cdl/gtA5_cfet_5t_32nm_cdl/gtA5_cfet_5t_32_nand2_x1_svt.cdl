.subckt gtA5_cfet_5t_32_nand2_x1_svt A B Y VDD VSS
*.PININFO A:I B:I Y:O VDD:B VSS:B
MM3 net13 A VSS VSS nmos_svt WGAA=0.032u L=0.012u M=1
MM1 Y B net13 VSS nmos_svt WGAA=0.032u L=0.012u M=1
MM0 Y B VDD VDD pmos_svt WGAA=0.032u L=0.012u M=1
MM2 Y A VDD VDD pmos_svt WGAA=0.032u L=0.012u M=1
.ends gtA5_cfet_5t_32_nand2_x1_svt
