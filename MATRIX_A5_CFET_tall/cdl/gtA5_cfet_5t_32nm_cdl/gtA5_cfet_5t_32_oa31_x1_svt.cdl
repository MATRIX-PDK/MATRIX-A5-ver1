.subckt gtA5_cfet_5t_32_oa31_x1_svt A1 A2 A3 B Y VDD VSS
*.PININFO A1:I A2:I A3:I B:I Y:O VDD:B VSS:B
MM35 net116 A3 net115 VDD pmos_svt WGAA=0.032u L=0.012u M=1
MM27 net115 A2 net69 VDD pmos_svt WGAA=0.032u L=0.012u M=1
MM33 Y net116 VDD VDD pmos_svt WGAA=0.032u L=0.012u M=1
MM28 net116 B VDD VDD pmos_svt WGAA=0.032u L=0.012u M=1
MM26 net69 A1 VDD VDD pmos_svt WGAA=0.032u L=0.012u M=1
MM29 net91 B VSS VSS nmos_svt WGAA=0.032u L=0.012u M=1
MM34 Y net116 VSS VSS nmos_svt WGAA=0.032u L=0.012u M=1
MM37 net116 A3 net91 VSS nmos_svt WGAA=0.032u L=0.012u M=1
MM31 net116 A1 net91 VSS nmos_svt WGAA=0.032u L=0.012u M=1
MM30 net116 A2 net91 VSS nmos_svt WGAA=0.032u L=0.012u M=1
.ends gtA5_cfet_5t_32_oa31_x1_svt
